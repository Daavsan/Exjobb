** Profile: "SCHEMATIC1-Trans"  [ C:\Users\A1201-admin\Documents\Exjobb\Orcad\mostest_cadence-pspicefiles\schematic1\trans.sim ]

** Creating circuit file "Trans.cir"
** WARNING: THIS AUTOMATICALLY GENERATED FILE MAY BE OVERWRITTEN BY SUBSEQUENT SIMULATIONS

*Libraries:
* Profile Libraries :
* Local Libraries :
* From [PSPICE NETLIST] section of C:\Users\A1201-admin\cdssetup\OrCAD_PSpice\22.1.0\PSpice.ini file:
.lib "C:\Users\A1201-admin\Documents\Exjobb\Orcad\lmg1210.lib"
.lib "nom.lib"

*Analysis directives:
.TRAN  0 1000ns 0 100n
.OPTIONS ADVCONV
.OPTIONS TRANCONV
.OPTIONS ABSTOL= 1u
.OPTIONS VNTOL= 1u
.AUTOCONVERGE ITL1=1000 ITL2=1000 ITL4=1000 RELTOL=0.05 ABSTOL=1.0E-5 VNTOL=1.0E-4 PIVTOL=1.0E-10
.PROBE64 V(alias(*)) I(alias(*)) W(alias(*)) D(alias(*)) NOISE(alias(*))
.INC "..\SCHEMATIC1.net"

.END
